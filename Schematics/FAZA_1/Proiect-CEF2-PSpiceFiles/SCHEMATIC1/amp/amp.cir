** Profile: "SCHEMATIC1-amp"  [ C:\Users\crist\Desktop\test\Proiect-CEF2-PSpiceFiles\SCHEMATIC1\amp.sim ]

** Creating circuit file "amp.cir"
** WARNING: THIS AUTOMATICALLY GENERATED FILE MAY BE OVERWRITTEN BY SUBSEQUENT SIMULATIONS

*Libraries:
* Profile Libraries :
* Local Libraries :
.LIB "C:/Users/crist/Desktop/lib_modelepspice_anexa_1/lib_modelepspice_anexa_1/modele_a1_lib/1n4148.lib"
.LIB "C:/Users/crist/Desktop/lib_modelepspice_anexa_1/lib_modelepspice_anexa_1/modele_a1_lib/bc807-25.lib"
.LIB "C:/Users/crist/Desktop/lib_modelepspice_anexa_1/lib_modelepspice_anexa_1/modele_a1_lib/bc817-25.lib"
.LIB "C:/Users/crist/Desktop/lib_modelepspice_anexa_1/lib_modelepspice_anexa_1/modele_a1_lib/bc846b.lib"
.LIB "C:/Users/crist/Desktop/lib_modelepspice_anexa_1/lib_modelepspice_anexa_1/modele_a1_lib/bc856b.lib"
.LIB "C:/Users/crist/Desktop/lib_modelepspice_anexa_1/lib_modelepspice_anexa_1/modele_a1_lib/bzx84c2v7.lib"
.LIB "C:/Users/crist/Desktop/lib_modelepspice_anexa_1/lib_modelepspice_anexa_1/modele_a1_lib/bzx84c5v1.lib"
.LIB "C:/Users/crist/Desktop/lib_modelepspice_anexa_1/lib_modelepspice_anexa_1/modele_a1_lib/bzx84c5v6.lib"
.LIB "C:/Users/crist/Desktop/lib_modelepspice_anexa_1/lib_modelepspice_anexa_1/modele_a1_lib/bzx84c6v2.lib"
.LIB "C:/Users/crist/Desktop/lib_modelepspice_anexa_1/lib_modelepspice_anexa_1/modele_a1_lib/bzx84c6v8.lib"
.LIB "C:/Users/crist/Desktop/lib_modelepspice_anexa_1/lib_modelepspice_anexa_1/modele_a1_lib/bzx84c8v2.lib"
.LIB "C:/Users/crist/Desktop/lib_modelepspice_anexa_1/lib_modelepspice_anexa_1/modele_a1_lib/bzx84c10.lib"
.LIB "C:/Users/crist/Desktop/lib_modelepspice_anexa_1/lib_modelepspice_anexa_1/modele_a1_lib/irfr120npbf.lib"
.LIB "C:/Users/crist/Desktop/lib_modelepspice_anexa_1/lib_modelepspice_anexa_1/modele_a1_lib/mjd31cg.lib"
.LIB "C:/Users/crist/Desktop/lib_modelepspice_anexa_1/lib_modelepspice_anexa_1/modele_a1_lib/mjd32cg.lib"
.LIB "C:/Users/crist/Desktop/lib_modelepspice_anexa_1/lib_modelepspice_anexa_1/modele_a1_lib/mmbfj177lt1g.lib"
.LIB "C:/Users/crist/Desktop/lib_modelepspice_anexa_1/lib_modelepspice_anexa_1/modele_a1_lib/mmbfj309lt1g.lib"
* From [PSPICE NETLIST] section of C:\Users\crist\AppData\Roaming\SPB_Data\cdssetup\OrCAD_PSpice\17.2.0\PSpice.ini file:
.lib "nomd.lib"

*Analysis directives:
.AC LIN 20 1 1M
.TEMP 0 27 60
.OPTIONS ADVCONV
.PROBE64 V(alias(*)) I(alias(*)) W(alias(*)) D(alias(*)) NOISE(alias(*))
.INC "..\SCHEMATIC1.net"

.END
